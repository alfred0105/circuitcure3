* Independent RC charging evaluation circuit
V1 VIN 0 PULSE(0 5 0 1u 1u 100m 200m)
RCHARGE VIN VC 100k
C1 VC 0 100u
RBLEED VC 0 100k
.tran 100u 50m
.end
