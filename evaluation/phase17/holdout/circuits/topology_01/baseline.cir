V1 VIN 0 DC 5
R1 VIN N1 1k
R2 N1 0 2k
R3 N1 VOUT 1k
R4 VOUT 0 2k
C1 VOUT 0 10u
.tran 10u 10m
.end
