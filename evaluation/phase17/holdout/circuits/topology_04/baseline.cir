V1 VIN 0 DC 5
R1 VIN LEFT 1k
R2 LEFT 0 2.2k
R3 VIN RIGHT 1.5k
R4 RIGHT 0 2.7k
R5 LEFT RIGHT 820
.tran 10u 5m
.end
