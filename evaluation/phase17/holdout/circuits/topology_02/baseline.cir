V1 VIN 0 PULSE(0 5 0 1u 1u 10m 20m)
R1 VIN N1 2.2k
C1 N1 0 4.7u
R2 N1 VOUT 3.3k
C2 VOUT 0 10u
R3 VOUT 0 100k
.tran 20u 8m
.end
