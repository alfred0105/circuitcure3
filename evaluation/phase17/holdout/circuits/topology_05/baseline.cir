V1 VIN 0 DC 12
VREG VOUT 0 DC 5
R1 VOUT LOAD 470
R2 LOAD 0 1k
C1 VOUT 0 100u
.tran 10u 5m
.end
